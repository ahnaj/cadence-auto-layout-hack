; SPDX-License-Identifier: MIT
procedure(alVal(items key @optional fallback)
 let((entry) entry=assoc(key items) if(entry cadr(entry) fallback)))
procedure(alCfg(key @optional fallback) alVal(ALconfig key fallback))
procedure(alBox(x0 y0 x1 y1) list(list(x0 y0) list(x1 y1)))
procedure(alX0(b) xCoord(car(b)))
procedure(alY0(b) yCoord(car(b)))
procedure(alX1(b) xCoord(cadr(b)))
procedure(alY1(b) yCoord(cadr(b)))
procedure(alW(b) alX1(b)-alX0(b))
procedure(alH(b) alY1(b)-alY0(b))
procedure(alCenter(b) list((alX0(b)+alX1(b))/2.0 (alY0(b)+alY1(b))/2.0))
procedure(alMove(b x y)
 alBox(alX0(b)+x alY0(b)+y alX1(b)+x alY1(b)+y))
procedure(alOverlap(a b @optional (space 0.0))
 alX0(a)<alX1(b)+space-1e-8 && alX1(a)>alX0(b)-space+1e-8 &&
 alY0(a)<alY1(b)+space-1e-8 && alY1(a)>alY0(b)-space+1e-8)
procedure(alSnapUp(x grid) ceiling(x/grid-1e-8)*grid)
procedure(alName(value)
 unless(stringp(value) && strlen(value)>0 error("Empty/non-string database name"))
 when(index(value "\n") || index(value "\r") error("Control characters in a database name"))
 value)
procedure(alNumber(value context)
 let((dots digits ch result)
  if(numberp(value) then result=value else
   unless(stringp(value) error("Unsupported parameter %s: %L" context value))
   dots=0 digits=0
   for(i 1 strlen(value)
    ch=substring(value i 1)
    if(ch=="." then dots=dots+1 else
     unless(member(ch '("0" "1" "2" "3" "4" "5" "6" "7" "8" "9"))
      error("Use a numeric micron-valued parameter for %s, got %L" context value))
     digits=digits+1))
   unless(dots<=1 && digits>0 error("Invalid numeric parameter %s" context))
   result=atof(value))
  unless(result>0 error("Nonpositive parameter %s" context))
  result))
procedure(alProp(inst name @optional fallback)
 let((prop param)
  prop=car(setof(p inst~>prop p~>name==name))
  if(prop prop~>value
   progn(param=cdfFindParamByName(cdfGetInstCDF(inst) name)
    if(param param~>value fallback)))))
procedure(alDirection(cv name)
 let((term) term=dbFindTermByName(cv name)
  unless(term error("Missing source terminal %s" name)) term~>direction))

; Local PRNG state avoids changing Virtuoso's session-global random generator.
procedure(alRng(seed)
 let((rng)
  unless(integerp(seed) && seed>=0 && seed<=2147483646 error("Invalid routing seed"))
  rng=makeTable('alRandom nil) rng["state"]=mod(seed 2147483646)+1 rng))
procedure(alRand(rng bound)
 let((value)
  unless(integerp(bound) && bound>0 error("Invalid random bound"))
  value=rng["state"]*48271.0
  rng["state"]=fix(value-floor(value/2147483647.0)*2147483647.0)
  mod(rng["state"] bound)))
procedure(alShuffle(items rng)
 prog((array count idx j value result)
  unless(items return(nil))
  count=length(items) array=makeVector(count nil) idx=0
  foreach(item items array[idx]=item idx=idx+1)
  idx=count-1
  while(idx>0
   j=alRand(rng idx+1) value=array[idx] array[idx]=array[j] array[j]=value idx=idx-1)
  for(idx 0 count-1 result=cons(array[idx] result))
  return(reverse(result))))
