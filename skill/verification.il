; SPDX-License-Identifier: MIT
procedure(alAudit(lib cell)
 let((cv tech count)
  unless(ddGetObj(lib cell "layout") error("ddGetObj cannot see generated layout"))
  cv=dbOpenCellViewByType(lib cell "layout" "maskLayout" "a")
  unless(cv error("Generated layout is not editable"))
  tech=techGetTechFile(cv)
  unless(tech && tech~>libName==alCfg("technology_library") error("Wrong attached technology"))
  count=length(cv~>shapes)+length(cv~>instances)
  unless(count>0 error("Empty layout"))
  foreach(i cv~>instances unless(i~>master error("Unresolved physical instance %s" i~>name)))
  foreach(term cv~>terminals unless(term~>pins error("Missing physical pin %s" term~>name)))
  printf("AL_AUDIT %s %s shapes=%d instances=%d pins=%d bbox=%L\n"
   lib cell length(cv~>shapes) length(cv~>instances) length(cv~>terminals) cv~>bBox)
  printf("AL_MEASURED width=%g height=%g area=%g\n" alW(cv~>bBox) alH(cv~>bBox) alW(cv~>bBox)*alH(cv~>bBox))
  foreach(term cv~>terminals printf("AL_PIN %s %s shapes=%d\n" term~>name term~>direction length(term~>pins)))
  dbClose(cv) t))
procedure(alVerify(lib cell sourceLib sourceCell sourceView runDir)
 let((win cv result markers extracted)
  alAudit(lib cell)
  win=deOpenCellView(lib cell "layout" "maskLayout" nil "a")
  unless(win error("Cannot create native verification editor context"))
  hiSetCurrentWindow(win) cv=geGetWindowCellView(win)
  result=ivDRC(?cell cv ?full t ?join nil ?rulesFromUnix t ?rulesFilePath alCfg("drc_rules"))
  unless(result error("Diva DRC did not execute"))
  markers=setof(m cv~>shapes m~>drcWhy)
  printf("AL_DRC markers=%d\n" length(markers))
  foreach(m markers printf("AL_VIOLATION %s bbox=%L\n" m~>drcWhy m~>bBox))
  result=ivExtract(?cell cv ?full t ?join nil ?rulesFromUnix t ?rulesFilePath alCfg("extraction_rules"))
  unless(result error("Diva extraction did not execute"))
  extracted=dbOpenCellViewByType(lib cell "extracted" "" "r")
  unless(extracted error("Diva did not create an extracted view"))
  printf("AL_EXTRACT instances=%d terminals=%d\n" length(extracted~>instances) length(extracted~>terminals))
  dbClose(extracted) dbSave(cv)
  result=ivLVS(strcat(runDir "/lvs") lib cell "extracted" t sourceLib sourceCell sourceView t
   nil t t nil "" nil 0 t "" alCfg("lvs_rules") nil "" nil)
  unless(result error("Diva LVS did not start"))
  printf("AL_LVS_STARTED\n")
  hiCloseWindow(win)
  t))
